
// TODOs:
// define errors; overflows....
// in status register


enum adc_mode {
  IDLE                 = 0x00;
  SINGLE_ACQ_F0        = 0x04;
  CONTINUOUS_ACQ_F0_F1 = 0x10;
};


addrmap adc_acquisition_reg {
  desc = "Registers for interfacing with the ADC Acquisition Controller & DMA";
  default regwidth = 32;
  
  /////////////////////////////////////
  // ctrl, status, config //
  /////////////////////////////////////

  reg {
    name = "Control";
    desc = "execute commands directly by writing single command bits";
    
    field {
      name = "reset_write_head";
      desc = "Resets the write head position back to F0_START_ADDR";
      hw   = r;
      sw   = w;
      singlepulse;
    } RESET_WRITE_HEAD = 0;

    field clr_fx_full_f {
      name = "Clear Status Fx Full";
      desc = "Resets the status Fx_FULL register";
      hw   = r;
      sw   = w;
      singlepulse;
    };

    clr_fx_full_f CLEAR_F0_FULL = 0;
    clr_fx_full_f CLEAR_F1_FULL = 0;
    
  } CNTRL;

  reg {
    name="Status";
    desc="status register for adc controller";

    field fx_full_f {
      name = "Block Fx Full";
      desc = "High if the Fx Block was fully written";
      hw   = rw;
      sw   = r;
    };

    fx_full_f F0_FULL = 0;
    fx_full_f F1_FULL = 0;

  } STATUS;

  reg {
    name="Config";
    desc="config register for adc controller";
    
    field {
      name   = "Acquisition System Mode";
      desc   = "configure acquisition system mode (idle, running in mode x, ...)";
      hw     = rw;
      sw     = rw;
      encode = adc_mode;
    } MODE[8] = adc_mode::IDLE;

  } CONF;


  /////////////////////////////////////
  // memory addresses (word aligned) //
  /////////////////////////////////////

  reg {
    name="Write Head";
    desc="Pointer to the current memory address the acquisition is writing to, (can be reset using the control reg)";
    field {
      name="Pointer";
      hw = rw;
      sw = r;
    } WORD_ADDRESS[31:2] = 0x00000000;
  } WRITE_HEAD;

  reg address_config_r {
    name="Address Configuration";
    field {
      name="Address";
      hw=r;
      sw=w;
    } WORD_ADDRESS[31:2] = 0x00000000;
  };

  address_config_r F0_START_ADDR;
  address_config_r F0_END_ADDR;
  address_config_r F1_START_ADDR;
  address_config_r F1_END_ADDR;

};